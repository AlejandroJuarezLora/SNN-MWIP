`include "disciplines.vams"
`include "constants.vams"

//definicion de macros
`define init_macro(nam,def,uni,lwr,upr,des) (*units=uni, type="instance", desc=des*) parameter real nam=def from [lwr:upr];

//https://gemini.google.com/share/0cd514a2e9f6
module mwip_dynamics(torque, x, theta, v_x, v_theta);
    // Port Definitions
    input torque;
    output x, theta, v_x, v_theta;
    electrical torque, theta, x;
    // Internal nodes for state derivatives
    electrical  v_x, v_theta;

    // Parameters (Example values for a small robot)
    parameter real M = 0.5;    // Mass of the cart/wheels (kg)
    parameter real m = 0.2;    // Mass of the pendulum (kg)
    parameter real l = 0.3;    // Length to center of mass (m)
    parameter real g = 9.81;   // Gravity (m/s^2)
    parameter real J = 0.006;  // Pendulum inertia (kg*m^2)
    `init_macro(init_x, 0, "V", -4.8, 4.8, "Initial position [-4.8m, 4.8m]")
    `init_macro(init_theta, 0.1, "V", -0.41887903, 0.41887903, "Initial anlge [-0.41887903, 0.41887903] [rad] (24deg)")
    `init_macro(init_v_x, 0, "V", -5, 5, "Initial velocity in x [-inf,inf]")
    `init_macro(init_v_theta, 0, "V",  -5, 5, "Initial angle velocity [-inf,inf]")

    // Internal State Variables (Integrators)
    // real v_x, v_theta; // Velocities
    real a_x, a_theta; // Accelerations

    // Intermediate variables for the Inertia Matrix
    real det, E11, E12, E21, E22;

    analog begin
        @(initial_step) begin
            $strobe("x0: %f", init_x);
            $strobe("th: %f", init_theta);
            $strobe("vx0: %f", init_v_x);
            $strobe("vth0: %f", init_v_theta);
        end

        // 1. Define the Inertia Matrix Elements
        E11 = M + m;
        E12 = m * l * cos(V(theta));
        E21 = m * l * cos(V(theta));
        E22 = J + m * pow(l, 2);

        // Determinant for matrix inversion
        det = (E11 * E22) - (E12 * E21);

        // 2. Solve for Accelerations (Derived from Lagrangian Dynamics)
        // This is a simplified version of the coupled ODEs:
        // (M+m)x'' + ml*cos(th)th'' - ml*sin(th)th'^2 = Force
        // ml*cos(th)x'' + (J+ml^2)th'' - mgl*sin(th) = 0

        a_theta = ( (E11 * m * g * l * sin(V(theta))) - (E21 * (V(torque) + m * l * pow(ddt(V(theta)), 2) * sin(V(theta)))) ) / det;
        a_x     = ( (V(torque) + m * l * pow(ddt(V(theta)), 2) * sin(V(theta))) - (E12 * a_theta) ) / E11;

        // 3. Perform Integration using ddt()
        // x' = v, v' = a
        V(x) <+ idt(V(v_x), init_x);
        V(v_x) <+ idt(a_x, init_v_x);

        // theta' = omega, omega' = alpha
        V(theta) <+ idt(V(v_theta), init_theta); // Initial tilt of 0.1 rad to test stability
        V(v_theta) <+ idt(a_theta, init_v_theta);

    end
endmodule
