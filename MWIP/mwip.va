`include "disciplines.vams"
`include "constants.vams"
//https://gemini.google.com/app/37102043ad932edb

`define macroEntrada(nam,def,uni,lwr,upr,des) (*units=uni, type="instance", desc=des*) parameter real nam=def from [lwr:upr];

module mwip_dynamics(torque, x, theta, dx, dth);
    // Port Definitions
    input torque;
    output x, theta, dx, dth;
    electrical torque, x, theta, dx, dth;

    // Parameters
    parameter real M = 0.5;
    parameter real m = 0.2;
    parameter real l = 0.3;
    parameter real g = 9.81;
    parameter real J = 0.006;
    parameter real t_step = 1.0e-3     from (0:inf);     // maximum time step [seconds]
    parameter real xmin = -4.8;                         // minimum x position [meters]
    parameter real xmax = 4.8;                          // maximun x position [meters]
    parameter real dxmin = -5;                          // minimum dx velocity [meters/s]
    parameter real dxmax = 5;                           // maximum dx velocity [meters/s]
    parameter real thmin = -0.4184;                         // minimum th position [radians]
    parameter real thmax = 0.4184;                          // maximun th position [radians]
    parameter real dthmin = -5;                          // minimum dth velocity [radians/s]
    parameter real dthmax = 5;                           // maximum dth velocity [radians/s]

    `macroEntrada(x0, 1, "m", xmin,xmax, "Initial x")
    `macroEntrada(dx0, 1, "m/s", dxmin, dxmax, "Initial dx")
    `macroEntrada(th0, 0.1, "rad", thmin, thmax, "Initial th")
    `macroEntrada(dth0, 0.01, "rad/s", dthmin, dthmax, "Initial dth")

    // Internal variables for calculation
    real det, E11, E12, E21, E22;
    real f1, f2; // Force vectors
    real a_x, a_theta, v_x, v_th, p_x, p_th;

    // transient simulation parameters
    real t_current;              // current time step [s]
    real t_previous;             // previous time step [s]
    real t_delta;                // difference between current vs. previous time step

    analog function real soft_minmax;
        input x, xmin, xmax;
        real x, xmin, xmax;
        begin
            if (x > xmax) begin
                soft_minmax = xmax;
            end else if (x < xmin) begin
                soft_minmax = xmin;
            end else begin
                soft_minmax = x;
            end
        end
    endfunction // soft_minmax

    analog begin
        @(initial_step) begin
            v_x = dx0;
            v_th = dth0;
            p_x = x0;
            p_th = dth0;
            $display("Simulation started. th0 is %g, x0 is %g", p_th, p_x);
        end
        // ... inside analog begin ...
        // $bound_step(t_step); // bound maximum time step
        t_current = $abstime; // current time
        t_delta = t_current - t_previous;

        // 1. Calculate physics using internal variables
        E11 = M + m;
        E12 = m * l * cos(V(theta));
        E22 = J + m * pow(l, 2);
        det = (E11 * E22) - pow(E12, 2);

        f1 = V(torque) + m * l * pow(V(dth), 2) * sin(V(theta));
        f2 = m * g * l * sin(V(theta));

        a_x     = (f1 * E22 - E12 * f2) / (det + 1e-15);
        a_theta = (E11 * f2 - E12 * f1) / (det + 1e-15);

        v_x = v_x + a_x * t_delta;
        v_th = v_th + a_theta * t_delta;

        //softminmax velocidades
        v_x = soft_minmax(v_x, dxmin, dxmax);
        v_th = soft_minmax(v_th, dthmin, dthmax);

        p_x = p_x + v_x * t_delta;
        p_th = p_th + v_th * t_delta;

        //softminmax positions
        p_x = soft_minmax(p_x, dxmin, dxmax);
        p_th = soft_minmax(p_th, dthmin, dthmax);

        // 2. The Robust Integrator Pattern
        // We integrate the acceleration to get a REAL value first,
        // then we contribute that value to the NODE.
        V(dx)    <+ v_x;
        V(dth)   <+ v_th;

        // Use the newly integrated velocity to find position
        V(x)     <+ p_x;
        V(theta) <+ p_th;

        // Debug check
        // $strobe("T: %g | Acc_th: %g | Acc_x: %g | vel_x: %g | vel_th: %g | p_x: %g | p_th: %g", $abstime, a_theta,a_x, V(dx), V(dth), V(x), V(theta));
        t_previous = $abstime; // current time step is previous time step for next iteration
    end
endmodule
