** sch_path: /foss/designs/SNN-MWIP/tb_net_mwip.sch
**.subckt tb_net_mwip
x1 VDD GND e_x tau_nom x_nom dx_nom th_nom dth_nom e_th 4x1_net
XM1 tau x th dx dth mwip_v0
V1 VDD GND 1.8
alimit1 %vd( dth GND ) %vd( net1 GND ) alimit1
.model alimit1 limit ( gain='0.9/5' out_lower_limit=0 out_upper_limit=0.9 )
alimit2 %vd( th GND ) %vd( net2 GND ) alimit2
.model alimit2 limit ( gain='0.9/0.4148' out_lower_limit=0 out_upper_limit=0.9 )
alimit3 %vd( dx GND ) %vd( net3 GND ) alimit3
.model alimit3 limit ( gain='0.9/5' out_lower_limit=0 out_upper_limit=0.9 )
alimit4 %vd( x GND ) %vd( net4 GND ) alimit4
.model alimit4 limit ( gain='0.9/4.8' out_lower_limit=0 out_upper_limit=0.9 )
V2 dth_nom net1 0.9
V3 th_nom net2 0.9
V4 dx_nom net3 0.9
V5 x_nom net4 0.9
alimit5 %vd( x x_ref ) %vd( net5 GND ) alimit5
.model alimit5 limit ( gain='1.8/5' out_lower_limit=-0.9 out_upper_limit=0.9 )
alimit6 %vd( th th_ref ) %vd( net6 GND ) alimit6
.model alimit6 limit ( gain='1.8/5' out_lower_limit=-0.9 out_upper_limit=0.9 )
V6 x_ref GND 2.5
V7 e_x net5 0.9
V8 e_th net6 0.9
V9 th_ref GND 0
alimit7 %vd( tau_nom GND ) %vd( tau GND ) alimit7
.model alimit7 limit ( gain=100 out_lower_limit=-1 out_upper_limit=1 )
**** begin user architecture code

*MADE BY JORGE ALEJANDRO JUAREZ LORA IPN

.subckt rram_v0 TE BE
    *N1 TE BE rram_v0_model gap_initial=unif(0.9,0.79)
    N1 TE BE rram_v0_model
.ends rram_v0

.subckt mwip_v0 tau x th dx dth
    N1 Tau x th dx dth mwip_v0_model
.ends mwip_v0

.model mwip_v0_model mwip_dynamics
.model rram_v0_model rram_v0_va

.control
    pre_osdi /foss/designs/SNN-MWIP/Memristor/rram_v0.osdi
    pre_osdi /foss/designs/SNN-MWIP/MWIP/mwip.osdi
.endc

.lib /foss/pdks/sky130A/libs.tech/combined/sky130.lib.spice tt

.options method gear
.options KLU
.options noinit
.options set num_threads=8
.options set ng_nomodcheck
.options set skywaterpdk
.options set wr_vecnames
.options set wr_singlescale
.options numdgt = 2
.save x dx th dth tau
.tran 100n 0.5
.control
	run
	write /foss/designs/SNN-MWIP/data.raw
.endc

**** end user architecture code
**.ends

* expanding   symbol:  4x1_net.sym # of pins=9
** sym_path: /foss/designs/SNN-MWIP/4x1_net.sym
** sch_path: /foss/designs/SNN-MWIP/4x1_net.sch
.subckt 4x1_net avdd avss R1 y1 x1 x2 x3 x4 R2
*.ipin x1
*.iopin avdd
*.iopin avss
*.iopin y1
*.iopin R1
*.ipin x2
*.ipin x3
*.ipin x4
*.iopin R2
x1 avdd avss x1 hJ1 hJ1 hJ1 hJ1 layer_input
x6 avdd net2_7 net2_6 net2_5 net2_4 net2_3 net2_2 net2_1 net2_0 avss hK1 hK1 hK1 hK1 hK1 hK1 hK1 hK1 layer_hidden
x7 net1_3 net1_2 net1_1 net1_0 GND hL1 hL1 hL1 hL1 hK1 hK1 hK1 hK1 hK1 hK1 hK1 hK1 avdd stdp_8x4
x8 avdd net1_3 net1_2 net1_1 net1_0 GND hL1 hL1 hL1 hL1 y1 R1 R2 layer_output_rew
x2 avdd avss x2 hJ2 hJ2 hJ2 hJ2 layer_input
x3 avdd avss x3 hJ3 hJ3 hJ3 hJ3 layer_input
x4 avdd avss x4 hJ4 hJ4 hJ4 hJ4 layer_input
x5 avdd net2_7 net2_6 net2_5 net2_4 net2_3 net2_2 net2_1 net2_0 avss hK1 hK1 hK1 hK1 hK1 hK1 hK1 hK1 hJ1 hJ1 hJ1 hJ1 hJ2 hJ2 hJ2
+ hJ2 hJ3 hJ3 hJ3 hJ3 hJ4 hJ4 hJ4 hJ4 no_stdp_4x4x8
.ends

* expanding   symbol:  layer/layer_input.sym # of pins=4
** sym_path: /foss/designs/SNN-MWIP/layer/layer_input.sym
** sch_path: /foss/designs/SNN-MWIP/layer/layer_input.sch
.subckt layer_input vdd vss vin vout[3] vout[2] vout[1] vout[0]
*.iopin vdd
*.iopin vss
*.iopin vout[3],vout[2],vout[1],vout[0]
*.ipin vin
Xx2 net1 vdd vout[0] vileak vss ul_tun_final W_LEAK=0.8 CM=0.8p
XM2 vileak vileak vss vss sky130_fd_pr__nfet_01v8 L=0.15 W=10 nf=1 ad='int((nf+1)/2) * W/nf * 0.29' as='int((nf+2)/2) * W/nf * 0.29'
+ pd='2*int((nf+1)/2) * (W/nf + 0.29)' ps='2*int((nf+2)/2) * (W/nf + 0.29)' nrd='0.29 / W' nrs='0.29 / W' sa=0 sb=0 sd=0 mult=1 m=1
I1 vdd vileak 100nA
Xx1 net2 vdd vout[1] vileak vss ul_tun_final W_LEAK=0.9 CM=0.8p
Xx3 net3 vdd vout[2] vileak vss ul_tun_final W_LEAK=1 CM=0.8p
Xx4 net4 vdd vout[3] vileak vss ul_tun_final W_LEAK=1.1 CM=0.8p
x5 vdd net1 net2 net3 net4 vin net5 vss otavccs4
XM1 net5 vin vss vss sky130_fd_pr__nfet_01v8 L=0.15 W=5 nf=1 ad=1.45 as=1.45 pd=10.58 ps=10.58 nrd=0.058 nrs=0.058 sa=0 sb=0 sd=0
+ mult=1 m=1
XM3 net5 net5 vdd vdd sky130_fd_pr__pfet_01v8 L=0.15 W=5 nf=1 ad=1.45 as=1.45 pd=10.58 ps=10.58 nrd=0.058 nrs=0.058 sa=0 sb=0 sd=0
+ mult=1 m=1
**** begin user architecture code

.save vout

**** end user architecture code
.ends

* expanding   symbol:  layer/layer_hidden.sym # of pins=4
** sym_path: /foss/designs/SNN-MWIP/layer/layer_hidden.sym
** sch_path: /foss/designs/SNN-MWIP/layer/layer_hidden.sch
.subckt layer_hidden vdd Iext[7] Iext[6] Iext[5] Iext[4] Iext[3] Iext[2] Iext[1] Iext[0] vss vout[7] vout[6] vout[5] vout[4]
+ vout[3] vout[2] vout[1] vout[0]
*.iopin vdd
*.iopin vss
*.iopin Iext[7],Iext[6],Iext[5],Iext[4],Iext[3],Iext[2],Iext[1],Iext[0]
*.iopin vout[7],vout[6],vout[5],vout[4],vout[3],vout[2],vout[1],vout[0]
Xx6 Iext[0] vdd vout[0] vileak vss ul_tun_final W_LEAK=1.15 CM=0.8p
XM2 vileak vileak vss vss sky130_fd_pr__nfet_01v8 L=0.15 W=10 nf=1 ad='int((nf+1)/2) * W/nf * 0.29' as='int((nf+2)/2) * W/nf * 0.29'
+ pd='2*int((nf+1)/2) * (W/nf + 0.29)' ps='2*int((nf+2)/2) * (W/nf + 0.29)' nrd='0.29 / W' nrs='0.29 / W' sa=0 sb=0 sd=0 mult=1 m=1
I1 vdd vileak 100nA
Xx1 Iext[1] vdd vout[1] vileak vss ul_tun_final W_LEAK=1.1 CM=0.8p
Xx2 Iext[2] vdd vout[2] vileak vss ul_tun_final W_LEAK=1.05 CM=0.8p
Xx3 Iext[3] vdd vout[3] vileak vss ul_tun_final W_LEAK=1 CM=0.8p
Xx8 Iext[7] vdd vout[7] vileak vss ul_tun_final W_LEAK=1 CM=0.8p
Xx4 Iext[4] vdd vout[4] vileak vss ul_tun_final W_LEAK=1.15 CM=0.8p
Xx5 Iext[5] vdd vout[5] vileak vss ul_tun_final W_LEAK=1.1 CM=0.8p
Xx7 Iext[6] vdd vout[6] vileak vss ul_tun_final W_LEAK=1.05 CM=0.8p
.ends

* expanding   symbol:  Synapse/stdp_8x4.sym # of pins=5
** sym_path: /foss/designs/SNN-MWIP/Synapse/stdp_8x4.sym
** sch_path: /foss/designs/SNN-MWIP/Synapse/stdp_8x4.sch
.subckt stdp_8x4 i_post[3] i_post[2] i_post[1] i_post[0] vssa vout_post[3] vout_post[2] vout_post[1] vout_post[0] vout_pre[7]
+ vout_pre[6] vout_pre[5] vout_pre[4] vout_pre[3] vout_pre[2] vout_pre[1] vout_pre[0] vdda
*.iopin vdda
*.iopin vssa
*.iopin vout_pre[7],vout_pre[6],vout_pre[5],vout_pre[4],vout_pre[3],vout_pre[2],vout_pre[1],vout_pre[0]
*.iopin vout_post[3],vout_post[2],vout_post[1],vout_post[0]
*.iopin i_post[3],i_post[2],i_post[1],i_post[0]
xstdp2 vdda vssa vout_pre[0] vout_post[1] i_post[1] n_vout_pre1 n_vout_post2 stdp_min
xstdp3 vdda vssa vout_pre[0] vout_post[2] i_post[2] n_vout_pre1 n_vout_post3 stdp_min
xstdp4 vdda vssa vout_pre[0] vout_post[3] i_post[3] n_vout_pre1 n_vout_post4 stdp_min
xstdp5 vdda vssa vout_pre[1] vout_post[0] i_post[0] n_vout_pre2 n_vout_post1 stdp_min
xstdp6 vdda vssa vout_pre[1] vout_post[1] i_post[1] n_vout_pre2 n_vout_post2 stdp_min
xstdp7 vdda vssa vout_pre[1] vout_post[2] i_post[2] n_vout_pre2 n_vout_post3 stdp_min
xstdp8 vdda vssa vout_pre[1] vout_post[3] i_post[3] n_vout_pre2 n_vout_post4 stdp_min
xstdp9 vdda vssa vout_pre[2] vout_post[0] i_post[0] n_vout_pre3 n_vout_post1 stdp_min
xstdp10 vdda vssa vout_pre[2] vout_post[1] i_post[1] n_vout_pre3 n_vout_post2 stdp_min
xstdp11 vdda vssa vout_pre[2] vout_post[2] i_post[2] n_vout_pre3 n_vout_post3 stdp_min
xstdp12 vdda vssa vout_pre[2] vout_post[3] i_post[3] n_vout_pre3 n_vout_post4 stdp_min
xstdp13 vdda vssa vout_pre[3] vout_post[0] i_post[0] n_vout_pre4 n_vout_post1 stdp_min
xstdp14 vdda vssa vout_pre[3] vout_post[1] i_post[1] n_vout_pre4 n_vout_post2 stdp_min
xstdp15 vdda vssa vout_pre[3] vout_post[2] i_post[2] n_vout_pre4 n_vout_post3 stdp_min
xstdp16 vdda vssa vout_pre[3] vout_post[3] i_post[3] n_vout_pre4 n_vout_post4 stdp_min
xstdp17 vdda vssa vout_pre[4] vout_post[0] i_post[0] n_vout_pre5 n_vout_post1 stdp_min
xstdp18 vdda vssa vout_pre[4] vout_post[1] i_post[1] n_vout_pre5 n_vout_post2 stdp_min
xstdp19 vdda vssa vout_pre[4] vout_post[2] i_post[2] n_vout_pre5 n_vout_post3 stdp_min
xstdp20 vdda vssa vout_pre[4] vout_post[3] i_post[3] n_vout_pre5 n_vout_post4 stdp_min
xstdp21 vdda vssa vout_pre[5] vout_post[0] i_post[0] n_vout_pre6 n_vout_post1 stdp_min
xstdp22 vdda vssa vout_pre[5] vout_post[1] i_post[1] n_vout_pre6 n_vout_post2 stdp_min
xstdp23 vdda vssa vout_pre[5] vout_post[2] i_post[2] n_vout_pre6 n_vout_post3 stdp_min
xstdp24 vdda vssa vout_pre[5] vout_post[3] i_post[3] n_vout_pre6 n_vout_post4 stdp_min
xstdp25 vdda vssa vout_pre[6] vout_post[0] i_post[0] n_vout_pre7 n_vout_post1 stdp_min
xstdp26 vdda vssa vout_pre[6] vout_post[1] i_post[1] n_vout_pre7 n_vout_post2 stdp_min
xstdp27 vdda vssa vout_pre[6] vout_post[2] i_post[2] n_vout_pre7 n_vout_post3 stdp_min
xstdp28 vdda vssa vout_pre[6] vout_post[3] i_post[3] n_vout_pre7 n_vout_post4 stdp_min
xstdp29 vdda vssa n_vout_pre8 vout_post[0] i_post[0] vout_pre[7] n_vout_post1 stdp_min
xstdp30 vdda vssa n_vout_pre8 vout_post[1] i_post[1] vout_pre[7] n_vout_post2 stdp_min
xstdp31 vdda vssa n_vout_pre8 vout_post[2] i_post[2] vout_pre[7] n_vout_post3 stdp_min
xstdp32 vdda vssa n_vout_pre8 vout_post[3] i_post[3] vout_pre[7] n_vout_post4 stdp_min
xstdp1 vdda vssa vout_pre[0] vout_post[0] i_post[0] n_vout_pre1 n_vout_post1 stdp_min
x1 vdda vout_pre[0] n_vout_pre1 vssa not
x2 vdda vout_pre[1] n_vout_pre2 vssa not
x3 vdda vout_pre[2] n_vout_pre3 vssa not
x4 vdda vout_pre[3] n_vout_pre4 vssa not
x5 vdda vout_pre[4] n_vout_pre5 vssa not
x6 vdda vout_pre[5] n_vout_pre6 vssa not
x7 vdda vout_pre[6] n_vout_pre7 vssa not
x8 vdda vout_pre[7] n_vout_pre8 vssa not
x9 vdda vout_post[0] n_vout_post1 vssa not
x10 vdda vout_post[1] n_vout_post2 vssa not
x11 vdda vout_post[2] n_vout_post3 vssa not
x12 vdda vout_post[3] n_vout_post4 vssa not
.ends

* expanding   symbol:  /foss/designs/SNN-MWIP/layer/layer_output_rew.sym # of pins=7
** sym_path: /foss/designs/SNN-MWIP/layer/layer_output_rew.sym
** sch_path: /foss/designs/SNN-MWIP/layer/layer_output_rew.sch
.subckt layer_output_rew vdd Iext[3] Iext[2] Iext[1] Iext[0] vss vout[3] vout[2] vout[1] vout[0] hx Vrew1 Vrew2
*.iopin vdd
*.iopin vss
*.ipin Iext[3],Iext[2],Iext[1],Iext[0]
*.iopin hx
*.iopin vout[3],vout[2],vout[1],vout[0]
*.iopin Vrew1
*.iopin Vrew2
Xx2 Iext[0] vdd vout[0] Vrew1 vss ul_tun_final W_LEAK=1 CM=0.8p
Xx1 Iext[1] vdd vout[1] Vrew1 vss ul_tun_final W_LEAK=1.1 CM=0.8p
Xx3 Iext[2] vdd vout[2] Vrew2 vss ul_tun_final W_LEAK=1.05 CM=0.8p
Xx4 Iext[3] vdd vout[3] Vrew2 vss ul_tun_final W_LEAK=1.15 CM=0.8p
XM7 net1 vout[0] GND GND sky130_fd_pr__nfet_01v8 L=0.15 W=5 nf=1 ad='int((nf+1)/2) * W/nf * 0.29' as='int((nf+2)/2) * W/nf * 0.29'
+ pd='2*int((nf+1)/2) * (W/nf + 0.29)' ps='2*int((nf+2)/2) * (W/nf + 0.29)' nrd='0.29 / W' nrs='0.29 / W' sa=0 sb=0 sd=0 mult=1 m=1
XM8 net1 vout[1] GND GND sky130_fd_pr__nfet_01v8 L=0.15 W=5 nf=1 ad='int((nf+1)/2) * W/nf * 0.29' as='int((nf+2)/2) * W/nf * 0.29'
+ pd='2*int((nf+1)/2) * (W/nf + 0.29)' ps='2*int((nf+2)/2) * (W/nf + 0.29)' nrd='0.29 / W' nrs='0.29 / W' sa=0 sb=0 sd=0 mult=1 m=1
XM9 net1 vout[2] GND GND sky130_fd_pr__nfet_01v8 L=0.15 W=5 nf=1 ad='int((nf+1)/2) * W/nf * 0.29' as='int((nf+2)/2) * W/nf * 0.29'
+ pd='2*int((nf+1)/2) * (W/nf + 0.29)' ps='2*int((nf+2)/2) * (W/nf + 0.29)' nrd='0.29 / W' nrs='0.29 / W' sa=0 sb=0 sd=0 mult=1 m=1
XM10 net1 vout[3] GND GND sky130_fd_pr__nfet_01v8 L=0.15 W=5 nf=1 ad='int((nf+1)/2) * W/nf * 0.29' as='int((nf+2)/2) * W/nf * 0.29'
+ pd='2*int((nf+1)/2) * (W/nf + 0.29)' ps='2*int((nf+2)/2) * (W/nf + 0.29)' nrd='0.29 / W' nrs='0.29 / W' sa=0 sb=0 sd=0 mult=1 m=1
x5 VDD hx net1 GND integrator
.ends

* expanding   symbol:  /foss/designs/SNN-MWIP/Synapse/no_stdp_4x4x8.sym # of pins=8
** sym_path: /foss/designs/SNN-MWIP/Synapse/no_stdp_4x4x8.sym
** sch_path: /foss/designs/SNN-MWIP/Synapse/no_stdp_4x4x8.sch
.subckt no_stdp_4x4x8 vdda i_post[7] i_post[6] i_post[5] i_post[4] i_post[3] i_post[2] i_post[1] i_post[0] vssa vout_post[7]
+ vout_post[6] vout_post[5] vout_post[4] vout_post[3] vout_post[2] vout_post[1] vout_post[0] vout_pre[3] vout_pre[2] vout_pre[1] vout_pre[0]
+ vout_pre2[3] vout_pre2[2] vout_pre2[1] vout_pre2[0] vout_pre3[3] vout_pre3[2] vout_pre3[1] vout_pre3[0] vout_pre4[3] vout_pre4[2] vout_pre4[1]
+ vout_pre4[0]
*.iopin vdda
*.iopin vssa
*.iopin vout_pre[3],vout_pre[2],vout_pre[1],vout_pre[0]
*.iopin vout_post[7],vout_post[6],vout_post[5],vout_post[4],vout_post[3],vout_post[2],vout_post[1],vout_post[0]
*.iopin i_post[7],i_post[6],i_post[5],i_post[4],i_post[3],i_post[2],i_post[1],i_post[0]
*.iopin vout_pre2[3],vout_pre2[2],vout_pre2[1],vout_pre2[0]
*.iopin vout_pre3[3],vout_pre3[2],vout_pre3[1],vout_pre3[0]
*.iopin vout_pre4[3],vout_pre4[2],vout_pre4[1],vout_pre4[0]
xno_stdp1 vdda vssa vout_pre[0] vout_post[0] i_post[0] n_vout_pre[0] n_vout_post[0] no_stdp
xno_stdp2 vdda vssa vout_pre[0] vout_post[1] i_post[1] n_vout_pre[0] n_vout_post[1] no_stdp
xno_stdp3 vdda vssa vout_pre[0] vout_post[2] i_post[2] n_vout_pre[0] n_vout_post[2] no_stdp
xno_stdp4 vdda vssa vout_pre[0] vout_post[3] i_post[3] n_vout_pre[0] n_vout_post[3] no_stdp
xno_stdp5 vdda vssa vout_pre[1] vout_post[0] i_post[0] n_vout_pre[1] n_vout_post[0] no_stdp
xno_stdp6 vdda vssa vout_pre[1] vout_post[1] i_post[1] n_vout_pre[1] n_vout_post[1] no_stdp
xno_stdp7 vdda vssa vout_pre[1] vout_post[2] i_post[2] n_vout_pre[1] n_vout_post[2] no_stdp
xno_stdp8 vdda vssa vout_pre[1] vout_post[3] i_post[3] n_vout_pre[1] n_vout_post[3] no_stdp
xno_stdp9 vdda vssa vout_pre[2] vout_post[0] i_post[0] n_vout_pre[2] n_vout_post[0] no_stdp
xno_stdp10 vdda vssa vout_pre[2] vout_post[1] i_post[1] n_vout_pre[2] n_vout_post[1] no_stdp
xno_stdp11 vdda vssa vout_pre[2] vout_post[2] i_post[2] n_vout_pre[2] n_vout_post[2] no_stdp
xno_stdp12 vdda vssa vout_pre[2] vout_post[3] i_post[3] n_vout_pre[2] n_vout_post[3] no_stdp
xno_stdp13 vdda vssa vout_pre[3] vout_post[0] i_post[0] n_vout_pre[3] n_vout_post[0] no_stdp
xno_stdp14 vdda vssa vout_pre[3] vout_post[1] i_post[1] n_vout_pre[3] n_vout_post[1] no_stdp
xno_stdp15 vdda vssa vout_pre[3] vout_post[2] i_post[2] n_vout_pre[3] n_vout_post[2] no_stdp
xno_stdp16 vdda vssa vout_pre[3] vout_post[3] i_post[3] n_vout_pre[3] n_vout_post[3] no_stdp
xno_stdp17 vdda vssa vout_pre[0] vout_post[4] i_post[4] n_vout_pre[0] n_vout_post[4] no_stdp
xno_stdp18 vdda vssa vout_pre[0] vout_post[5] i_post[5] n_vout_pre[0] n_vout_post[5] no_stdp
xno_stdp19 vdda vssa vout_pre[0] vout_post[6] i_post[6] n_vout_pre[0] n_vout_post[6] no_stdp
xno_stdp20 vdda vssa vout_pre[0] vout_post[7] i_post[7] n_vout_pre[0] n_vout_post[7] no_stdp
xno_stdp21 vdda vssa vout_pre[1] vout_post[4] i_post[4] n_vout_pre[1] n_vout_post[4] no_stdp
xno_stdp22 vdda vssa vout_pre[1] vout_post[5] i_post[5] n_vout_pre[1] n_vout_post[5] no_stdp
xno_stdp23 vdda vssa vout_pre[1] vout_post[6] i_post[6] n_vout_pre[1] n_vout_post[6] no_stdp
xno_stdp24 vdda vssa vout_pre[1] vout_post[7] i_post[7] n_vout_pre[1] n_vout_post[7] no_stdp
xno_stdp25 vdda vssa vout_pre[2] vout_post[4] i_post[4] n_vout_pre[2] n_vout_post[4] no_stdp
xno_stdp26 vdda vssa vout_pre[2] vout_post[5] i_post[5] n_vout_pre[2] n_vout_post[5] no_stdp
xno_stdp27 vdda vssa vout_pre[2] vout_post[6] i_post[6] n_vout_pre[2] n_vout_post[6] no_stdp
xno_stdp28 vdda vssa vout_pre[2] vout_post[7] i_post[7] n_vout_pre[2] n_vout_post[7] no_stdp
xno_stdp29 vdda vssa vout_pre[3] vout_post[4] i_post[4] n_vout_pre[3] n_vout_post[4] no_stdp
xno_stdp30 vdda vssa vout_pre[3] vout_post[5] i_post[5] n_vout_pre[3] n_vout_post[5] no_stdp
xno_stdp31 vdda vssa vout_pre[3] vout_post[6] i_post[6] n_vout_pre[3] n_vout_post[6] no_stdp
xno_stdp32 vdda vssa vout_pre[3] vout_post[7] i_post[7] n_vout_pre[3] n_vout_post[7] no_stdp
x1 vdda vout_pre[0] n_vout_pre[0] vssa not
x2 vdda vout_pre[1] n_vout_pre[1] vssa not
x3 vdda vout_pre[2] n_vout_pre[2] vssa not
x4 vdda vout_pre[3] n_vout_pre[3] vssa not
x5 vdda vout_post[0] n_vout_post[0] vssa not
x6 vdda vout_post[1] n_vout_post[1] vssa not
x7 vdda vout_post[2] n_vout_post[2] vssa not
x8 vdda vout_post[3] n_vout_post[3] vssa not
x9 vdda vout_post[4] n_vout_post[4] vssa not
x10 vdda vout_post[5] n_vout_post[5] vssa not
x11 vdda vout_post[6] n_vout_post[6] vssa not
x12 vdda vout_post[7] n_vout_post[7] vssa not
xno_stdp33 vdda vssa vout_pre2[0] vout_post[0] i_post[0] n_vout_pre2[0] n_vout_post[0] no_stdp
xno_stdp34 vdda vssa vout_pre2[0] vout_post[1] i_post[1] n_vout_pre2[0] n_vout_post[1] no_stdp
xno_stdp35 vdda vssa vout_pre2[0] vout_post[2] i_post[2] n_vout_pre2[0] n_vout_post[2] no_stdp
xno_stdp36 vdda vssa vout_pre2[0] vout_post[3] i_post[3] n_vout_pre2[0] n_vout_post[3] no_stdp
xno_stdp37 vdda vssa vout_pre2[1] vout_post[0] i_post[0] n_vout_pre2[1] n_vout_post[0] no_stdp
xno_stdp38 vdda vssa vout_pre2[1] vout_post[1] i_post[1] n_vout_pre2[1] n_vout_post[1] no_stdp
xno_stdp39 vdda vssa vout_pre2[1] vout_post[2] i_post[2] n_vout_pre2[1] n_vout_post[2] no_stdp
xno_stdp40 vdda vssa vout_pre2[1] vout_post[3] i_post[3] n_vout_pre2[1] n_vout_post[3] no_stdp
xno_stdp41 vdda vssa vout_pre2[2] vout_post[0] i_post[0] n_vout_pre2[2] n_vout_post[0] no_stdp
xno_stdp42 vdda vssa vout_pre2[2] vout_post[1] i_post[1] n_vout_pre2[2] n_vout_post[1] no_stdp
xno_stdp43 vdda vssa vout_pre2[2] vout_post[2] i_post[2] n_vout_pre2[2] n_vout_post[2] no_stdp
xno_stdp44 vdda vssa vout_pre2[2] vout_post[3] i_post[3] n_vout_pre2[2] n_vout_post[3] no_stdp
xno_stdp45 vdda vssa vout_pre2[3] vout_post[0] i_post[0] n_vout_pre2[3] n_vout_post[0] no_stdp
xno_stdp46 vdda vssa vout_pre2[3] vout_post[1] i_post[1] n_vout_pre2[3] n_vout_post[1] no_stdp
xno_stdp47 vdda vssa vout_pre2[3] vout_post[2] i_post[2] n_vout_pre2[3] n_vout_post[2] no_stdp
xno_stdp48 vdda vssa vout_pre2[3] vout_post[3] i_post[3] n_vout_pre2[3] n_vout_post[3] no_stdp
xno_stdp49 vdda vssa vout_pre2[0] vout_post[4] i_post[4] n_vout_pre2[0] n_vout_post[4] no_stdp
xno_stdp50 vdda vssa vout_pre2[0] vout_post[5] i_post[5] n_vout_pre2[0] n_vout_post[5] no_stdp
xno_stdp51 vdda vssa vout_pre2[0] vout_post[6] i_post[6] n_vout_pre2[0] n_vout_post[6] no_stdp
xno_stdp52 vdda vssa vout_pre2[0] vout_post[7] i_post[7] n_vout_pre2[0] n_vout_post[7] no_stdp
xno_stdp53 vdda vssa vout_pre2[1] vout_post[4] i_post[4] n_vout_pre2[1] n_vout_post[4] no_stdp
xno_stdp54 vdda vssa vout_pre2[1] vout_post[5] i_post[5] n_vout_pre2[1] n_vout_post[5] no_stdp
xno_stdp55 vdda vssa vout_pre2[1] vout_post[6] i_post[6] n_vout_pre2[1] n_vout_post[6] no_stdp
xno_stdp56 vdda vssa vout_pre2[1] vout_post[7] i_post[7] n_vout_pre2[1] n_vout_post[7] no_stdp
xno_stdp57 vdda vssa vout_pre2[2] vout_post[4] i_post[4] n_vout_pre2[2] n_vout_post[4] no_stdp
xno_stdp58 vdda vssa vout_pre2[2] vout_post[5] i_post[5] n_vout_pre2[2] n_vout_post[5] no_stdp
xno_stdp59 vdda vssa vout_pre2[2] vout_post[6] i_post[6] n_vout_pre2[2] n_vout_post[6] no_stdp
xno_stdp60 vdda vssa vout_pre2[2] vout_post[7] i_post[7] n_vout_pre2[2] n_vout_post[7] no_stdp
xno_stdp61 vdda vssa vout_pre2[3] vout_post[4] i_post[4] n_vout_pre2[3] n_vout_post[4] no_stdp
xno_stdp62 vdda vssa vout_pre2[3] vout_post[5] i_post[5] n_vout_pre2[3] n_vout_post[5] no_stdp
xno_stdp63 vdda vssa vout_pre2[3] vout_post[6] i_post[6] n_vout_pre2[3] n_vout_post[6] no_stdp
xno_stdp64 vdda vssa vout_pre2[3] vout_post[7] i_post[7] n_vout_pre2[3] n_vout_post[7] no_stdp
x13 vdda vout_pre2[0] n_vout_pre2[0] vssa not
x14 vdda vout_pre2[1] n_vout_pre2[1] vssa not
x15 vdda vout_pre2[2] n_vout_pre2[2] vssa not
x16 vdda vout_pre2[3] n_vout_pre2[3] vssa not
xno_stdp65 vdda vssa vout_pre3[0] vout_post[0] i_post[0] n_vout_pre3[0] n_vout_post[0] no_stdp
xno_stdp66 vdda vssa vout_pre3[0] vout_post[1] i_post[1] n_vout_pre3[0] n_vout_post[1] no_stdp
xno_stdp67 vdda vssa vout_pre3[0] vout_post[2] i_post[2] n_vout_pre3[0] n_vout_post[2] no_stdp
xno_stdp68 vdda vssa vout_pre3[0] vout_post[3] i_post[3] n_vout_pre3[0] n_vout_post[3] no_stdp
xno_stdp69 vdda vssa vout_pre3[1] vout_post[0] i_post[0] n_vout_pre3[1] n_vout_post[0] no_stdp
xno_stdp70 vdda vssa vout_pre3[1] vout_post[1] i_post[1] n_vout_pre3[1] n_vout_post[1] no_stdp
xno_stdp71 vdda vssa vout_pre3[1] vout_post[2] i_post[2] n_vout_pre3[1] n_vout_post[2] no_stdp
xno_stdp72 vdda vssa vout_pre3[1] vout_post[3] i_post[3] n_vout_pre3[1] n_vout_post[3] no_stdp
xno_stdp73 vdda vssa vout_pre3[2] vout_post[0] i_post[0] n_vout_pre3[2] n_vout_post[0] no_stdp
xno_stdp74 vdda vssa vout_pre3[2] vout_post[1] i_post[1] n_vout_pre3[2] n_vout_post[1] no_stdp
xno_stdp75 vdda vssa vout_pre3[2] vout_post[2] i_post[2] n_vout_pre3[2] n_vout_post[2] no_stdp
xno_stdp76 vdda vssa vout_pre3[2] vout_post[3] i_post[3] n_vout_pre3[2] n_vout_post[3] no_stdp
xno_stdp77 vdda vssa vout_pre3[3] vout_post[0] i_post[0] n_vout_pre3[3] n_vout_post[0] no_stdp
xno_stdp78 vdda vssa vout_pre3[3] vout_post[1] i_post[1] n_vout_pre3[3] n_vout_post[1] no_stdp
xno_stdp79 vdda vssa vout_pre3[3] vout_post[2] i_post[2] n_vout_pre3[3] n_vout_post[2] no_stdp
xno_stdp80 vdda vssa vout_pre3[3] vout_post[3] i_post[3] n_vout_pre3[3] n_vout_post[3] no_stdp
xno_stdp81 vdda vssa vout_pre3[0] vout_post[4] i_post[4] n_vout_pre3[0] n_vout_post[4] no_stdp
xno_stdp82 vdda vssa vout_pre3[0] vout_post[5] i_post[5] n_vout_pre3[0] n_vout_post[5] no_stdp
xno_stdp83 vdda vssa vout_pre3[0] vout_post[6] i_post[6] n_vout_pre3[0] n_vout_post[6] no_stdp
xno_stdp84 vdda vssa vout_pre3[0] vout_post[7] i_post[7] n_vout_pre3[0] n_vout_post[7] no_stdp
xno_stdp85 vdda vssa vout_pre3[1] vout_post[4] i_post[4] n_vout_pre3[1] n_vout_post[4] no_stdp
xno_stdp86 vdda vssa vout_pre3[1] vout_post[5] i_post[5] n_vout_pre3[1] n_vout_post[5] no_stdp
xno_stdp87 vdda vssa vout_pre3[1] vout_post[6] i_post[6] n_vout_pre3[1] n_vout_post[6] no_stdp
xno_stdp88 vdda vssa vout_pre3[1] vout_post[7] i_post[7] n_vout_pre3[1] n_vout_post[7] no_stdp
xno_stdp89 vdda vssa vout_pre3[2] vout_post[4] i_post[4] n_vout_pre3[2] n_vout_post[4] no_stdp
xno_stdp90 vdda vssa vout_pre3[2] vout_post[5] i_post[5] n_vout_pre3[2] n_vout_post[5] no_stdp
xno_stdp91 vdda vssa vout_pre3[2] vout_post[6] i_post[6] n_vout_pre3[2] n_vout_post[6] no_stdp
xno_stdp92 vdda vssa vout_pre3[2] vout_post[7] i_post[7] n_vout_pre3[2] n_vout_post[7] no_stdp
xno_stdp93 vdda vssa vout_pre3[3] vout_post[4] i_post[4] n_vout_pre3[3] n_vout_post[4] no_stdp
xno_stdp94 vdda vssa vout_pre3[3] vout_post[5] i_post[5] n_vout_pre3[3] n_vout_post[5] no_stdp
xno_stdp95 vdda vssa vout_pre3[3] vout_post[6] i_post[6] n_vout_pre3[3] n_vout_post[6] no_stdp
xno_stdp96 vdda vssa vout_pre3[3] vout_post[7] i_post[7] n_vout_pre3[3] n_vout_post[7] no_stdp
x17 vdda vout_pre3[0] n_vout_pre3[0] vssa not
x18 vdda vout_pre3[1] n_vout_pre3[1] vssa not
x19 vdda vout_pre3[2] n_vout_pre3[2] vssa not
x20 vdda vout_pre3[3] n_vout_pre3[3] vssa not
xno_stdp97 vdda vssa vout_pre4[0] vout_post[0] i_post[0] n_vout_pre4[0] n_vout_post[0] no_stdp
xno_stdp98 vdda vssa vout_pre4[0] vout_post[1] i_post[1] n_vout_pre4[0] n_vout_post[1] no_stdp
xno_stdp99 vdda vssa vout_pre4[0] vout_post[2] i_post[2] n_vout_pre4[0] n_vout_post[2] no_stdp
xno_stdp100 vdda vssa vout_pre4[0] vout_post[3] i_post[3] n_vout_pre4[0] n_vout_post[3] no_stdp
xno_stdp101 vdda vssa vout_pre4[1] vout_post[0] i_post[0] n_vout_pre4[1] n_vout_post[0] no_stdp
xno_stdp102 vdda vssa vout_pre4[1] vout_post[1] i_post[1] n_vout_pre4[1] n_vout_post[1] no_stdp
xno_stdp103 vdda vssa vout_pre4[1] vout_post[2] i_post[2] n_vout_pre4[1] n_vout_post[2] no_stdp
xno_stdp104 vdda vssa vout_pre4[1] vout_post[3] i_post[3] n_vout_pre4[1] n_vout_post[3] no_stdp
xno_stdp105 vdda vssa vout_pre4[2] vout_post[0] i_post[0] n_vout_pre4[2] n_vout_post[0] no_stdp
xno_stdp106 vdda vssa vout_pre4[2] vout_post[1] i_post[1] n_vout_pre4[2] n_vout_post[1] no_stdp
xno_stdp107 vdda vssa vout_pre4[2] vout_post[2] i_post[2] n_vout_pre4[2] n_vout_post[2] no_stdp
xno_stdp108 vdda vssa vout_pre4[2] vout_post[3] i_post[3] n_vout_pre4[2] n_vout_post[3] no_stdp
xno_stdp109 vdda vssa vout_pre4[3] vout_post[0] i_post[0] n_vout_pre4[3] n_vout_post[0] no_stdp
xno_stdp110 vdda vssa vout_pre4[3] vout_post[1] i_post[1] n_vout_pre4[3] n_vout_post[1] no_stdp
xno_stdp111 vdda vssa vout_pre4[3] vout_post[2] i_post[2] n_vout_pre4[3] n_vout_post[2] no_stdp
xno_stdp112 vdda vssa vout_pre4[3] vout_post[3] i_post[3] n_vout_pre4[3] n_vout_post[3] no_stdp
xno_stdp113 vdda vssa vout_pre4[0] vout_post[4] i_post[4] n_vout_pre4[0] n_vout_post[4] no_stdp
xno_stdp114 vdda vssa vout_pre4[0] vout_post[5] i_post[5] n_vout_pre4[0] n_vout_post[5] no_stdp
xno_stdp115 vdda vssa vout_pre4[0] vout_post[6] i_post[6] n_vout_pre4[0] n_vout_post[6] no_stdp
xno_stdp116 vdda vssa vout_pre4[0] vout_post[7] i_post[7] n_vout_pre4[0] n_vout_post[7] no_stdp
xno_stdp117 vdda vssa vout_pre4[1] vout_post[4] i_post[4] n_vout_pre4[1] n_vout_post[4] no_stdp
xno_stdp118 vdda vssa vout_pre4[1] vout_post[5] i_post[5] n_vout_pre4[1] n_vout_post[5] no_stdp
xno_stdp119 vdda vssa vout_pre4[1] vout_post[6] i_post[6] n_vout_pre4[1] n_vout_post[6] no_stdp
xno_stdp120 vdda vssa vout_pre4[1] vout_post[7] i_post[7] n_vout_pre4[1] n_vout_post[7] no_stdp
xno_stdp121 vdda vssa vout_pre4[2] vout_post[4] i_post[4] n_vout_pre4[2] n_vout_post[4] no_stdp
xno_stdp122 vdda vssa vout_pre4[2] vout_post[5] i_post[5] n_vout_pre4[2] n_vout_post[5] no_stdp
xno_stdp123 vdda vssa vout_pre4[2] vout_post[6] i_post[6] n_vout_pre4[2] n_vout_post[6] no_stdp
xno_stdp124 vdda vssa vout_pre4[2] vout_post[7] i_post[7] n_vout_pre4[2] n_vout_post[7] no_stdp
xno_stdp125 vdda vssa vout_pre4[3] vout_post[4] i_post[4] n_vout_pre4[3] n_vout_post[4] no_stdp
xno_stdp126 vdda vssa vout_pre4[3] vout_post[5] i_post[5] n_vout_pre4[3] n_vout_post[5] no_stdp
xno_stdp127 vdda vssa vout_pre4[3] vout_post[6] i_post[6] n_vout_pre4[3] n_vout_post[6] no_stdp
xno_stdp128 vdda vssa vout_pre4[3] vout_post[7] i_post[7] n_vout_pre4[3] n_vout_post[7] no_stdp
x21 vdda vout_pre4[0] n_vout_pre4[0] vssa not
x22 vdda vout_pre4[1] n_vout_pre4[1] vssa not
x23 vdda vout_pre4[2] n_vout_pre4[2] vssa not
x24 vdda vout_pre4[3] n_vout_pre4[3] vssa not
.ends

* expanding   symbol:  Neuron/ul_tun_final.sym # of pins=5
** sym_path: /foss/designs/SNN-MWIP/Neuron/ul_tun_final.sym
** sch_path: /foss/designs/SNN-MWIP/Neuron/ul_tun_final.sch
.subckt ul_tun_final Iext vdd vout Vleak vss  W_LEAK=1 CM=1p
*.iopin Iext
*.iopin vout
*.iopin vss
*.iopin Vleak
*.iopin vdd
XM1 vout vout vm vdd sky130_fd_pr__pfet_01v8 L=10 W=1 nf=1 ad=0.29 as=0.29 pd=2.58 ps=2.58 nrd=0.29 nrs=0.29 sa=0 sb=0 sd=0 mult=1
+ m=1
XM2 vout net1 vm vdd sky130_fd_pr__pfet_01v8 L=0.15 W=1.5 nf=1 ad=0.435 as=0.435 pd=3.58 ps=3.58 nrd=0.193333333333333
+ nrs=0.193333333333333 sa=0 sb=0 sd=0 mult=1 m=1
XM3 net1 net1 vm vdd sky130_fd_pr__pfet_01v8 L=0.15 W=15 nf=1 ad=4.35 as=4.35 pd=30.58 ps=30.58 nrd=0.0193333333333333
+ nrs=0.0193333333333333 sa=0 sb=0 sd=0 mult=1 m=1
XM4 net1 vout vss vss sky130_fd_pr__nfet_01v8 L=5 W=1 nf=1 ad=0.29 as=0.29 pd=2.58 ps=2.58 nrd=0.29 nrs=0.29 sa=0 sb=0 sd=0 mult=1
+ m=1
C1 vm vss 1p m=1
XM9 net2 vout Iext vdd sky130_fd_pr__pfet_01v8 L=0.15 W=4 nf=1 ad=1.16 as=1.16 pd=8.58 ps=8.58 nrd=0.0725 nrs=0.0725 sa=0 sb=0
+ sd=0 mult=1 m=1
XM11 vout Vleak vss vss sky130_fd_pr__nfet_01v8 L=0.15 W=1 nf=1 ad='int((nf+1)/2) * W/nf * 0.29' as='int((nf+2)/2) * W/nf * 0.29' pd='2*int((nf+1)/2) * (W/nf + 0.29)'
+ ps='2*int((nf+2)/2) * (W/nf + 0.29)' nrd='0.29 / W' nrs='0.29 / W' sa=0 sb=0 sd=0 mult=1 m=1
vext net2 vm 0
.ends

* expanding   symbol:  /foss/designs/SNN-MWIP/VCCS/otavccs4.sym # of pins=8
** sym_path: /foss/designs/SNN-MWIP/VCCS/otavccs4.sym
** sch_path: /foss/designs/SNN-MWIP/VCCS/otavccs4.sch
.subckt otavccs4 avdd ipos1 ipos2 ineg2 ineg1 vin1 vin2 avss
*.iopin avdd
*.iopin avss
*.ipin vin1
*.ipin vin2
*.opin ineg2
*.opin ipos2
*.opin ipos1
*.opin ineg1
XM2 x vin1 net2 avss sky130_fd_pr__nfet_01v8 L=0.5 W=0.5 nf=1 ad=0.145 as=0.145 pd=1.58 ps=1.58 nrd=0.58 nrs=0.58 sa=0 sb=0 sd=0
+ mult=1 m=1
XM1 y vin2 net1 avss sky130_fd_pr__nfet_01v8 L=0.5 W=0.5 nf=1 ad=0.145 as=0.145 pd=1.58 ps=1.58 nrd=0.58 nrs=0.58 sa=0 sb=0 sd=0
+ mult=1 m=1
XM11 x x avdd avdd sky130_fd_pr__pfet_01v8 L=0.15 W=0.8 nf=1 ad=0.232 as=0.232 pd=2.18 ps=2.18 nrd=0.3625 nrs=0.3625 sa=0 sb=0
+ sd=0 mult=1 m=1
XM3 y y avdd avdd sky130_fd_pr__pfet_01v8 L=0.15 W=0.8 nf=1 ad=0.232 as=0.232 pd=2.18 ps=2.18 nrd=0.3625 nrs=0.3625 sa=0 sb=0 sd=0
+ mult=1 m=1
XM5 net3 y avdd avdd sky130_fd_pr__pfet_01v8 L=0.5 W=0.5 nf=1 ad=0.145 as=0.145 pd=1.58 ps=1.58 nrd=0.58 nrs=0.58 sa=0 sb=0 sd=0
+ mult=1 m=1
XM6 net6 y net3 avdd sky130_fd_pr__pfet_01v8 L=0.5 W=0.5 nf=1 ad=0.145 as=0.145 pd=1.58 ps=1.58 nrd=0.58 nrs=0.58 sa=0 sb=0 sd=0
+ mult=1 m=1
Vipos net6 ipos2 0
.save i(vipos)
XM7 net4 x avdd avdd sky130_fd_pr__pfet_01v8 L=0.5 W=0.5 nf=1 ad=0.145 as=0.145 pd=1.58 ps=1.58 nrd=0.58 nrs=0.58 sa=0 sb=0 sd=0
+ mult=1 m=1
XM8 net5 x net4 avdd sky130_fd_pr__pfet_01v8 L=0.5 W=0.5 nf=1 ad=0.145 as=0.145 pd=1.58 ps=1.58 nrd=0.58 nrs=0.58 sa=0 sb=0 sd=0
+ mult=1 m=1
Vineg2 net5 ineg2 0
.save i(vineg2)
R3 p avss 10k m=1
R6 p net2 40k m=1
R1 p net1 40k m=1
XM4 net7 y avdd avdd sky130_fd_pr__pfet_01v8 L=0.5 W=0.5 nf=1 ad=0.145 as=0.145 pd=1.58 ps=1.58 nrd=0.58 nrs=0.58 sa=0 sb=0 sd=0
+ mult=1 m=1
XM9 net8 y net7 avdd sky130_fd_pr__pfet_01v8 L=0.5 W=0.5 nf=1 ad=0.145 as=0.145 pd=1.58 ps=1.58 nrd=0.58 nrs=0.58 sa=0 sb=0 sd=0
+ mult=1 m=1
Vipos1 net8 ipos1 0
.save i(vipos1)
XM10 net9 x avdd avdd sky130_fd_pr__pfet_01v8 L=0.5 W=0.5 nf=1 ad=0.145 as=0.145 pd=1.58 ps=1.58 nrd=0.58 nrs=0.58 sa=0 sb=0 sd=0
+ mult=1 m=1
XM12 net10 x net9 avdd sky130_fd_pr__pfet_01v8 L=0.5 W=0.5 nf=1 ad=0.145 as=0.145 pd=1.58 ps=1.58 nrd=0.58 nrs=0.58 sa=0 sb=0 sd=0
+ mult=1 m=1
Vineg1 net10 ineg1 0
.save i(vineg1)
.ends

* expanding   symbol:  Synapse/stdp_min.sym # of pins=7
** sym_path: /foss/designs/SNN-MWIP/Synapse/stdp_min.sym
** sch_path: /foss/designs/SNN-MWIP/Synapse/stdp_min.sch
.subckt stdp_min vdd vss vout_pre vout_post I_post n_vout_pre n_vout_post
*.iopin vdd
*.iopin vss
*.iopin vout_post
*.iopin vout_pre
*.iopin I_post
*.iopin n_vout_post
*.iopin n_vout_pre
XM3 be vout_post vss vss sky130_fd_pr__nfet_01v8 L=0.15 W=0.5 nf=1 ad='int((nf+1)/2) * W/nf * 0.29' as='int((nf+2)/2) * W/nf * 0.29'
+ pd='2*int((nf+1)/2) * (W/nf + 0.29)' ps='2*int((nf+2)/2) * (W/nf + 0.29)' nrd='0.29 / W' nrs='0.29 / W' sa=0 sb=0 sd=0 mult=1 m=1
XM4 net1 vout_pre vss vss sky130_fd_pr__nfet_01v8 L=0.15 W=0.5 nf=1 ad='int((nf+1)/2) * W/nf * 0.29' as='int((nf+2)/2) * W/nf * 0.29'
+ pd='2*int((nf+1)/2) * (W/nf + 0.29)' ps='2*int((nf+2)/2) * (W/nf + 0.29)' nrd='0.29 / W' nrs='0.29 / W' sa=0 sb=0 sd=0 mult=1 m=1
XR2 be te rram_v0
XM14 net3 net2 vdd vdd sky130_fd_pr__pfet_01v8 L=0.15 W=0.5 nf=1 ad='int((nf+1)/2) * W/nf * 0.29' as='int((nf+2)/2) * W/nf * 0.29'
+ pd='2*int((nf+1)/2) * (W/nf + 0.29)' ps='2*int((nf+2)/2) * (W/nf + 0.29)' nrd='0.29 / W' nrs='0.29 / W' sa=0 sb=0 sd=0 mult=1 m=1
XM15 net2 net2 vdd vdd sky130_fd_pr__pfet_01v8 L=0.15 W=1 nf=1 ad='int((nf+1)/2) * W/nf * 0.29' as='int((nf+2)/2) * W/nf * 0.29' pd='2*int((nf+1)/2) * (W/nf + 0.29)'
+ ps='2*int((nf+2)/2) * (W/nf + 0.29)' nrd='0.29 / W' nrs='0.29 / W' sa=0 sb=0 sd=0 mult=1 m=1
Vmr te net1 0
.save i(vmr)
XM1 net1 n_vout_post net2 vdd sky130_fd_pr__pfet_01v8 L=0.15 W=1 nf=1 ad='int((nf+1)/2) * W/nf * 0.29' as='int((nf+2)/2) * W/nf * 0.29'
+ pd='2*int((nf+1)/2) * (W/nf + 0.29)' ps='2*int((nf+2)/2) * (W/nf + 0.29)' nrd='0.29 / W' nrs='0.29 / W' sa=0 sb=0 sd=0 mult=1 m=1
XM2 be n_vout_pre net2 vdd sky130_fd_pr__pfet_01v8 L=0.15 W=1 nf=1 ad='int((nf+1)/2) * W/nf * 0.29' as='int((nf+2)/2) * W/nf * 0.29'
+ pd='2*int((nf+1)/2) * (W/nf + 0.29)' ps='2*int((nf+2)/2) * (W/nf + 0.29)' nrd='0.29 / W' nrs='0.29 / W' sa=0 sb=0 sd=0 mult=1 m=1
XM6 I_post net2 net3 vdd sky130_fd_pr__pfet_01v8 L=0.15 W=0.5 nf=1 ad='int((nf+1)/2) * W/nf * 0.29' as='int((nf+2)/2) * W/nf * 0.29'
+ pd='2*int((nf+1)/2) * (W/nf + 0.29)' ps='2*int((nf+2)/2) * (W/nf + 0.29)' nrd='0.29 / W' nrs='0.29 / W' sa=0 sb=0 sd=0 mult=1 m=1
.ends

* expanding   symbol:  not.sym # of pins=4
** sym_path: /foss/designs/SNN-MWIP/not.sym
** sch_path: /foss/designs/SNN-MWIP/not.sch
.subckt not avdd vin vout avss
*.ipin vin
*.opin vout
*.iopin avdd
*.iopin avss
XM1 vout vin avss avss sky130_fd_pr__nfet_01v8 L=0.15 W=1 nf=1 ad=0.29 as=0.29 pd=2.58 ps=2.58 nrd=0.29 nrs=0.29 sa=0 sb=0 sd=0
+ mult=1 m=1
XM2 vout vin avdd avdd sky130_fd_pr__pfet_01v8 L=0.15 W=1 nf=1 ad=0.29 as=0.29 pd=2.58 ps=2.58 nrd=0.29 nrs=0.29 sa=0 sb=0 sd=0
+ mult=2 m=2
.ends

* expanding   symbol:  /foss/designs/SNN-BUCK-BOOST/layer/integrator.sym # of pins=4
** sym_path: /foss/designs/SNN-BUCK-BOOST/layer/integrator.sym
** sch_path: /foss/designs/SNN-BUCK-BOOST/layer/integrator.sch
.subckt integrator vdd Vout Ispks gnd
*.iopin Ispks
*.iopin Vout
*.iopin vdd
*.iopin gnd
XMIn Ispks vx vsyn vdd sky130_fd_pr__pfet_01v8 L=0.15 W=5 nf=1 ad='int((nf+1)/2) * W/nf * 0.29' as='int((nf+2)/2) * W/nf * 0.29' pd='2*int((nf+1)/2) * (W/nf + 0.29)'
+ ps='2*int((nf+2)/2) * (W/nf + 0.29)' nrd='0.29 / W' nrs='0.29 / W' sa=0 sb=0 sd=0 mult=1 m=1
XM3 vsyn vdd vdd vdd sky130_fd_pr__pfet_01v8 L=0.15 W=50 nf=1 ad='int((nf+1)/2) * W/nf * 0.29' as='int((nf+2)/2) * W/nf * 0.29' pd='2*int((nf+1)/2) * (W/nf + 0.29)'
+ ps='2*int((nf+2)/2) * (W/nf + 0.29)' nrd='0.29 / W' nrs='0.29 / W' sa=0 sb=0 sd=0 mult=3 m=3
XM4 Vout vsyn vdd vdd sky130_fd_pr__pfet_01v8 L=0.15 W=25 nf=1 ad='int((nf+1)/2) * W/nf * 0.29' as='int((nf+2)/2) * W/nf * 0.29' pd='2*int((nf+1)/2) * (W/nf + 0.29)'
+ ps='2*int((nf+2)/2) * (W/nf + 0.29)' nrd='0.29 / W' nrs='0.29 / W' sa=0 sb=0 sd=0 mult=2 m=2
XCsyn vdd vsyn sky130_fd_pr__cap_mim_m3_1 W=22.2 L=22.2 MF=1 m=1
XR2 vx vdd sky130_fd_pr__res_generic_po W=1 L=1 m=1
XR1 gnd vx sky130_fd_pr__res_generic_po W=1 L=1 m=1
XM6 Vout vx gnd gnd sky130_fd_pr__nfet_01v8 L=0.15 W=0.5 nf=1 ad='int((nf+1)/2) * W/nf * 0.29' as='int((nf+2)/2) * W/nf * 0.29' pd='2*int((nf+1)/2) * (W/nf + 0.29)'
+ ps='2*int((nf+2)/2) * (W/nf + 0.29)' nrd='0.29 / W' nrs='0.29 / W' sa=0 sb=0 sd=0 mult=1 m=1
.ends

* expanding   symbol:  Synapse/no_stdp.sym # of pins=7
** sym_path: /foss/designs/SNN-MWIP/Synapse/no_stdp.sym
** sch_path: /foss/designs/SNN-MWIP/Synapse/no_stdp.sch
.subckt no_stdp vdd vss vout_pre vout_post I_post n_vout_pre n_vout_post
*.iopin vdd
*.iopin vss
*.iopin vout_post
*.iopin vout_pre
*.iopin I_post
*.iopin n_vout_post
*.iopin n_vout_pre
XM3 be vout_post vss vss sky130_fd_pr__nfet_01v8 L=0.15 W=0.5 nf=1 ad='int((nf+1)/2) * W/nf * 0.29' as='int((nf+2)/2) * W/nf * 0.29'
+ pd='2*int((nf+1)/2) * (W/nf + 0.29)' ps='2*int((nf+2)/2) * (W/nf + 0.29)' nrd='0.29 / W' nrs='0.29 / W' sa=0 sb=0 sd=0 mult=1 m=1
XM4 net1 vout_pre vss vss sky130_fd_pr__nfet_01v8 L=0.15 W=0.5 nf=1 ad='int((nf+1)/2) * W/nf * 0.29' as='int((nf+2)/2) * W/nf * 0.29'
+ pd='2*int((nf+1)/2) * (W/nf + 0.29)' ps='2*int((nf+2)/2) * (W/nf + 0.29)' nrd='0.29 / W' nrs='0.29 / W' sa=0 sb=0 sd=0 mult=1 m=1
XM14 net3 net2 vdd vdd sky130_fd_pr__pfet_01v8 L=0.15 W=0.5 nf=1 ad='int((nf+1)/2) * W/nf * 0.29' as='int((nf+2)/2) * W/nf * 0.29'
+ pd='2*int((nf+1)/2) * (W/nf + 0.29)' ps='2*int((nf+2)/2) * (W/nf + 0.29)' nrd='0.29 / W' nrs='0.29 / W' sa=0 sb=0 sd=0 mult=1 m=1
XM15 net2 net2 vdd vdd sky130_fd_pr__pfet_01v8 L=0.15 W=1 nf=1 ad='int((nf+1)/2) * W/nf * 0.29' as='int((nf+2)/2) * W/nf * 0.29' pd='2*int((nf+1)/2) * (W/nf + 0.29)'
+ ps='2*int((nf+2)/2) * (W/nf + 0.29)' nrd='0.29 / W' nrs='0.29 / W' sa=0 sb=0 sd=0 mult=1 m=1
Vmr te net1 0
.save i(vmr)
XM1 net1 n_vout_post net2 vss sky130_fd_pr__pfet_01v8 L=0.15 W=1 nf=1 ad='int((nf+1)/2) * W/nf * 0.29' as='int((nf+2)/2) * W/nf * 0.29'
+ pd='2*int((nf+1)/2) * (W/nf + 0.29)' ps='2*int((nf+2)/2) * (W/nf + 0.29)' nrd='0.29 / W' nrs='0.29 / W' sa=0 sb=0 sd=0 mult=1 m=1
XM2 be n_vout_pre net2 vss sky130_fd_pr__pfet_01v8 L=0.15 W=1 nf=1 ad='int((nf+1)/2) * W/nf * 0.29' as='int((nf+2)/2) * W/nf * 0.29'
+ pd='2*int((nf+1)/2) * (W/nf + 0.29)' ps='2*int((nf+2)/2) * (W/nf + 0.29)' nrd='0.29 / W' nrs='0.29 / W' sa=0 sb=0 sd=0 mult=1 m=1
XM6 I_post net2 net3 vdd sky130_fd_pr__pfet_01v8 L=0.15 W=0.5 nf=1 ad='int((nf+1)/2) * W/nf * 0.29' as='int((nf+2)/2) * W/nf * 0.29'
+ pd='2*int((nf+1)/2) * (W/nf + 0.29)' ps='2*int((nf+2)/2) * (W/nf + 0.29)' nrd='0.29 / W' nrs='0.29 / W' sa=0 sb=0 sd=0 mult=1 m=1
R1 be te 'AGAUSS((3300000)/2,500000, 1)' m=1
.ends

.GLOBAL VDD
.GLOBAL GND
.GLOBAL avss
.GLOBAL avdd
.end
