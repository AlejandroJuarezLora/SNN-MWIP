** sch_path: /foss/designs/SNN-MWIP/tb_net_mwip.sch
**.subckt tb_net_mwip
x1 VDD GND e_x tau_nom x_nom dx_nom th_nom dth_nom e_th 4x1_net
XM1 tau x th dx dth mwip_v0
V1 VDD GND 1.8
alimit1 %vd( dth GND ) %vd( net1 GND ) alimit1
.model alimit1 limit ( gain='0.9/5' out_lower_limit=0 out_upper_limit=0.9 )
alimit2 %vd( th GND ) %vd( net2 GND ) alimit2
.model alimit2 limit ( gain='0.9/0.4148' out_lower_limit=0 out_upper_limit=0.9 )
alimit3 %vd( dx GND ) %vd( net3 GND ) alimit3
.model alimit3 limit ( gain='0.9/5' out_lower_limit=0 out_upper_limit=0.9 )
alimit4 %vd( x GND ) %vd( net4 GND ) alimit4
.model alimit4 limit ( gain='0.9/4.8' out_lower_limit=0 out_upper_limit=0.9 )
V2 dth_nom net1 0.9
V3 th_nom net2 0.9
V4 dx_nom net3 0.9
V5 x_nom net4 0.9
alimit5 %vd( x x_ref ) %vd( net5 GND ) alimit5
.model alimit5 limit ( gain='1.8/5' out_lower_limit=-0.9 out_upper_limit=0.9 )
alimit6 %vd( th th_ref ) %vd( net6 GND ) alimit6
.model alimit6 limit ( gain='1.8/5' out_lower_limit=-0.9 out_upper_limit=0.9 )
V6 x_ref GND 2.5
V7 e_x net5 0.9
V8 e_th net6 0.9
V9 th_ref GND 0
alimit7 %vd( tau_nom GND ) %vd( tau GND ) alimit7
.model alimit7 limit ( gain=100 out_lower_limit=-1 out_upper_limit=1 )
**** begin user architecture code

*MADE BY JORGE ALEJANDRO JUAREZ LORA IPN

.subckt rram_v1 TE BE
    N1 TE BE rram_v1_model gap_initial=unif(0.9,0.79)
    *N1 TE BE rram_v1_model
.ends rram_v1

.subckt mwip_v0 tau x th dx dth
    N1 Tau x th dx dth mwip_v0_model
.ends mwip_v0

.model mwip_v0_model mwip_dynamics
.model rram_v1_model rram_v1_va

.control
    pre_osdi /foss/designs/SNN-MWIP/Memristor/rram_v1.osdi
    pre_osdi /foss/designs/SNN-MWIP/MWIP/mwip.osdi
.endc

.lib /foss/pdks/sky130A/libs.tech/combined/sky130.lib.spice tt

.options method gear
.options KLU
.options noinit
.options set num_threads=8
.options set ng_nomodcheck
.options set skywaterpdk
.options set wr_vecnames
.options set wr_singlescale
.options numdgt = 2
*.save tau x dx th dth tau x_nom dx_nom th_nom dth_nom tau_nom e_x e_th
.save all
.tran 20n 0.5 uic
.control
	run
	write /foss/designs/SNN-MWIP/data.raw
.endc

**** end user architecture code
**.ends

* expanding   symbol:  4x1_net.sym # of pins=9
** sym_path: /foss/designs/SNN-MWIP/4x1_net.sym
** sch_path: /foss/designs/SNN-MWIP/4x1_net.sch
.subckt 4x1_net avdd avss R1 y1 x1 x2 x3 x4 R2
*.ipin x1
*.iopin avdd
*.iopin avss
*.iopin y1
*.iopin R1
*.ipin x2
*.ipin x3
*.ipin x4
*.iopin R2
x1 avdd avss x1 net10 net8 net7 net9 layer_input
x7 net17 GND net25 net8 avdd net9 net23 net1 net4 net6 net11 net13 net15 net7 net2 net5 net3 net10 net12 net14 net16 net26 net27
+ net28 net24 net21 net22 net18 net19 net20 stdp_8x4
x8 avdd net17 GND net25 y1 R1 R2 net23 net26 net27 net28 net24 net21 net22 net18 net19 net20 layer_output_rew
x2 avdd avss x2 net12 net1 net2 net11 layer_input
x3 avdd avss x3 net14 net4 net5 net13 layer_input
x4 avdd avss x4 net16 net6 net3 net15 layer_input
.ends

* expanding   symbol:  layer/layer_input.sym # of pins=7
** sym_path: /foss/designs/SNN-MWIP/layer/layer_input.sym
** sch_path: /foss/designs/SNN-MWIP/layer/layer_input.sch
.subckt layer_input vdd vss vin nvout2 vout1 vout2 nvout1
*.iopin vdd
*.iopin vss
*.ipin vin
*.iopin vout1
*.iopin vout2
*.iopin nvout1
*.iopin nvout2
Xx2 net2 vdd vout2 vileak vss nvout2 ul_tun_final W_LEAK=0.8 CM=0.8p
XM2 vileak vileak vss vss sky130_fd_pr__nfet_01v8 L=0.15 W=10 nf=1 ad='int((nf+1)/2) * W/nf * 0.29' as='int((nf+2)/2) * W/nf * 0.29'
+ pd='2*int((nf+1)/2) * (W/nf + 0.29)' ps='2*int((nf+2)/2) * (W/nf + 0.29)' nrd='0.29 / W' nrs='0.29 / W' sa=0 sb=0 sd=0 mult=1 m=1
I1 vdd vileak 100nA
Xx1 net1 vdd vout1 vileak vss nvout1 ul_tun_final W_LEAK=0.9 CM=0.8p
x5 vdd net1 net2 vin net3 vss otavccs4
XM1 net3 vin vss vss sky130_fd_pr__nfet_01v8 L=0.15 W=5 nf=1 ad=1.45 as=1.45 pd=10.58 ps=10.58 nrd=0.058 nrs=0.058 sa=0 sb=0 sd=0
+ mult=1 m=1
XM3 net3 net3 vdd vdd sky130_fd_pr__pfet_01v8 L=0.15 W=5 nf=1 ad=1.45 as=1.45 pd=10.58 ps=10.58 nrd=0.058 nrs=0.058 sa=0 sb=0 sd=0
+ mult=1 m=1
**** begin user architecture code

.save v(vout1) v(vout2)

**** end user architecture code
.ends

* expanding   symbol:  Synapse/stdp_8x4.sym # of pins=30
** sym_path: /foss/designs/SNN-MWIP/Synapse/stdp_8x4.sym
** sch_path: /foss/designs/SNN-MWIP/Synapse/stdp_8x4.sch
.subckt stdp_8x4 i_post0 vssa vout_post3 vout_pre0 vdda nvout_pre0 nvout_post1 vout_pre2 vout_pre4 vout_pre6 nvout_pre2 nvout_pre4
+ nvout_pre6 vout_pre1 vout_pre3 vout_pre5 vout_pre7 nvout_pre1 nvout_pre3 nvout_pre5 nvout_pre7 vout_post2 vout_post1 vout_post0 nvout_post0
+ nvout_post3 nvout_post2 i_post1 i_post2 i_post3
*.iopin vdda
*.iopin vssa
*.iopin vout_post0
*.iopin i_post0
*.iopin nvout_post0
*.iopin nvout_pre4
*.iopin nvout_pre2
*.iopin nvout_pre0
*.iopin nvout_pre6
*.iopin nvout_post1
*.iopin nvout_post2
*.iopin nvout_post3
*.iopin vout_post1
*.iopin vout_post2
*.iopin vout_post3
*.iopin i_post1
*.iopin i_post2
*.iopin i_post3
*.iopin nvout_pre5
*.iopin nvout_pre3
*.iopin nvout_pre1
*.iopin nvout_pre7
*.iopin vout_pre4
*.iopin vout_pre2
*.iopin vout_pre0
*.iopin vout_pre6
*.iopin vout_pre5
*.iopin vout_pre3
*.iopin vout_pre1
*.iopin vout_pre7
xstdp2 vdda vssa vout_pre0 vout_post1 i_post1 nvout_pre0 nvout_post1 stdp_min
xstdp3 vdda vssa vout_pre0 vout_post2 i_post2 nvout_pre0 nvout_post2 stdp_min
xstdp4 vdda vssa vout_pre0 vout_post3 i_post3 nvout_pre0 nvout_post3 stdp_min
xstdp5 vdda vssa vout_pre1 vout_post0 i_post0 nvout_pre1 nvout_post0 stdp_min
xstdp6 vdda vssa vout_pre1 vout_post1 i_post1 nvout_pre1 nvout_post1 stdp_min
xstdp7 vdda vssa vout_pre1 vout_post2 i_post2 nvout_pre1 nvout_post2 stdp_min
xstdp8 vdda vssa vout_pre1 vout_post3 i_post3 nvout_pre1 nvout_post3 stdp_min
xstdp9 vdda vssa vout_pre2 vout_post0 i_post0 nvout_pre2 nvout_post0 stdp_min
xstdp10 vdda vssa vout_pre2 vout_post1 i_post1 nvout_pre2 nvout_post1 stdp_min
xstdp11 vdda vssa vout_pre2 vout_post2 i_post2 nvout_pre2 nvout_post2 stdp_min
xstdp12 vdda vssa vout_pre2 vout_post3 i_post3 nvout_pre2 nvout_post3 stdp_min
xstdp13 vdda vssa vout_pre3 vout_post0 i_post0 nvout_pre3 nvout_post0 stdp_min
xstdp14 vdda vssa vout_pre3 vout_post1 i_post1 nvout_pre3 nvout_post1 stdp_min
xstdp15 vdda vssa vout_pre3 vout_post2 i_post2 nvout_pre3 nvout_post2 stdp_min
xstdp16 vdda vssa vout_pre3 vout_post3 i_post3 nvout_pre3 nvout_post3 stdp_min
xstdp17 vdda vssa vout_pre4 vout_post0 i_post0 nvout_pre4 nvout_post0 stdp_min
xstdp18 vdda vssa vout_pre4 vout_post1 i_post1 nvout_pre4 nvout_post1 stdp_min
xstdp19 vdda vssa vout_pre4 vout_post2 i_post2 nvout_pre4 nvout_post2 stdp_min
xstdp20 vdda vssa vout_pre4 vout_post3 i_post3 nvout_pre4 nvout_post3 stdp_min
xstdp21 vdda vssa vout_pre5 vout_post0 i_post0 nvout_pre5 nvout_post0 stdp_min
xstdp22 vdda vssa vout_pre5 vout_post1 i_post1 nvout_pre5 nvout_post1 stdp_min
xstdp23 vdda vssa vout_pre5 vout_post2 i_post2 nvout_pre5 nvout_post2 stdp_min
xstdp24 vdda vssa vout_pre5 vout_post3 i_post3 nvout_pre5 nvout_post3 stdp_min
xstdp25 vdda vssa vout_pre6 vout_post0 i_post0 nvout_pre6 nvout_post0 stdp_min
xstdp26 vdda vssa vout_pre6 vout_post1 i_post1 nvout_pre6 nvout_post1 stdp_min
xstdp27 vdda vssa vout_pre6 vout_post2 i_post2 nvout_pre6 nvout_post2 stdp_min
xstdp28 vdda vssa vout_pre6 vout_post3 i_post3 nvout_pre6 nvout_post3 stdp_min
xstdp29 vdda vssa nvout_pre7 vout_post0 i_post0 vout_pre7 nvout_post0 stdp_min
xstdp30 vdda vssa nvout_pre7 vout_post1 i_post1 vout_pre7 nvout_post1 stdp_min
xstdp31 vdda vssa nvout_pre7 vout_post2 i_post2 vout_pre7 nvout_post2 stdp_min
xstdp32 vdda vssa nvout_pre7 vout_post3 i_post3 vout_pre7 nvout_post3 stdp_min
xstdp1 vdda vssa vout_pre0 vout_post0 i_post0 nvout_pre0 nvout_post0 stdp_min
.ends

* expanding   symbol:  /foss/designs/SNN-MWIP/layer/layer_output_rew.sym # of pins=17
** sym_path: /foss/designs/SNN-MWIP/layer/layer_output_rew.sym
** sch_path: /foss/designs/SNN-MWIP/layer/layer_output_rew.sch
.subckt layer_output_rew vdd Iext0 vss vout3 hx Vrew1 Vrew2 nvout1 vout2 vout1 vout0 nvout0 nvout3 nvout2 Iext1 Iext2 Iext3
*.iopin vdd
*.iopin vss
*.ipin Iext0
*.iopin hx
*.iopin vout0
*.iopin Vrew1
*.iopin Vrew2
*.iopin vout1
*.iopin vout2
*.iopin vout3
*.iopin nvout0
*.iopin nvout1
*.iopin nvout2
*.iopin nvout3
*.ipin Iext1
*.ipin Iext2
*.ipin Iext3
Xx2 Iext0 vdd vout0 Vrew1 vss nvout0 ul_tun_final W_LEAK=1 CM=0.8p
Xx1 Iext1 vdd vout1 Vrew1 vss nvout1 ul_tun_final W_LEAK=1.1 CM=0.8p
Xx3 Iext2 vdd vout2 Vrew2 vss nvout2 ul_tun_final W_LEAK=1.05 CM=0.8p
Xx4 Iext3 vdd vout3 Vrew2 vss nvout3 ul_tun_final W_LEAK=1.15 CM=0.8p
XM7 net1 vout0 GND GND sky130_fd_pr__nfet_01v8 L=0.15 W=5 nf=1 ad='int((nf+1)/2) * W/nf * 0.29' as='int((nf+2)/2) * W/nf * 0.29' pd='2*int((nf+1)/2) * (W/nf + 0.29)'
+ ps='2*int((nf+2)/2) * (W/nf + 0.29)' nrd='0.29 / W' nrs='0.29 / W' sa=0 sb=0 sd=0 mult=1 m=1
XM8 net1 vout1 GND GND sky130_fd_pr__nfet_01v8 L=0.15 W=5 nf=1 ad='int((nf+1)/2) * W/nf * 0.29' as='int((nf+2)/2) * W/nf * 0.29' pd='2*int((nf+1)/2) * (W/nf + 0.29)'
+ ps='2*int((nf+2)/2) * (W/nf + 0.29)' nrd='0.29 / W' nrs='0.29 / W' sa=0 sb=0 sd=0 mult=1 m=1
XM9 net1 vout2 GND GND sky130_fd_pr__nfet_01v8 L=0.15 W=5 nf=1 ad='int((nf+1)/2) * W/nf * 0.29' as='int((nf+2)/2) * W/nf * 0.29' pd='2*int((nf+1)/2) * (W/nf + 0.29)'
+ ps='2*int((nf+2)/2) * (W/nf + 0.29)' nrd='0.29 / W' nrs='0.29 / W' sa=0 sb=0 sd=0 mult=1 m=1
XM10 net1 vout3 GND GND sky130_fd_pr__nfet_01v8 L=0.15 W=5 nf=1 ad='int((nf+1)/2) * W/nf * 0.29' as='int((nf+2)/2) * W/nf * 0.29' pd='2*int((nf+1)/2) * (W/nf + 0.29)'
+ ps='2*int((nf+2)/2) * (W/nf + 0.29)' nrd='0.29 / W' nrs='0.29 / W' sa=0 sb=0 sd=0 mult=1 m=1
x5 VDD hx net1 GND integrator
.ends

* expanding   symbol:  Neuron/ul_tun_final.sym # of pins=6
** sym_path: /foss/designs/SNN-MWIP/Neuron/ul_tun_final.sym
** sch_path: /foss/designs/SNN-MWIP/Neuron/ul_tun_final.sch
.subckt ul_tun_final Iext vdd vout Vleak vss nvout  W_LEAK=1 CM=1p
*.iopin Iext
*.iopin vout
*.iopin vss
*.iopin Vleak
*.iopin vdd
*.iopin nvout
XM1 vout vout vm vdd sky130_fd_pr__pfet_01v8 L=10 W=1 nf=1 ad=0.29 as=0.29 pd=2.58 ps=2.58 nrd=0.29 nrs=0.29 sa=0 sb=0 sd=0 mult=1
+ m=1
XM2 vout net1 vm vdd sky130_fd_pr__pfet_01v8 L=0.15 W=1.5 nf=1 ad=0.435 as=0.435 pd=3.58 ps=3.58 nrd=0.193333333333333
+ nrs=0.193333333333333 sa=0 sb=0 sd=0 mult=1 m=1
XM3 net1 net1 vm vdd sky130_fd_pr__pfet_01v8 L=0.15 W=15 nf=1 ad=4.35 as=4.35 pd=30.58 ps=30.58 nrd=0.0193333333333333
+ nrs=0.0193333333333333 sa=0 sb=0 sd=0 mult=1 m=1
XM4 net1 vout vss vss sky130_fd_pr__nfet_01v8 L=5 W=1 nf=1 ad=0.29 as=0.29 pd=2.58 ps=2.58 nrd=0.29 nrs=0.29 sa=0 sb=0 sd=0 mult=1
+ m=1
C1 vm vss 1p m=1
XM9 vm vout Iext vdd sky130_fd_pr__pfet_01v8 L=0.15 W=4 nf=1 ad=1.16 as=1.16 pd=8.58 ps=8.58 nrd=0.0725 nrs=0.0725 sa=0 sb=0 sd=0
+ mult=1 m=1
XM11 vout Vleak vss vss sky130_fd_pr__nfet_01v8 L=0.15 W=1 nf=1 ad='int((nf+1)/2) * W/nf * 0.29' as='int((nf+2)/2) * W/nf * 0.29' pd='2*int((nf+1)/2) * (W/nf + 0.29)'
+ ps='2*int((nf+2)/2) * (W/nf + 0.29)' nrd='0.29 / W' nrs='0.29 / W' sa=0 sb=0 sd=0 mult=1 m=1
XM5 vm nvout Iext vss sky130_fd_pr__nfet_01v8 L=0.15 W=2 nf=1 ad='int((nf+1)/2) * W/nf * 0.29' as='int((nf+2)/2) * W/nf * 0.29' pd='2*int((nf+1)/2) * (W/nf + 0.29)'
+ ps='2*int((nf+2)/2) * (W/nf + 0.29)' nrd='0.29 / W' nrs='0.29 / W' sa=0 sb=0 sd=0 mult=1 m=1
XM6 nvout vout vdd vdd sky130_fd_pr__pfet_01v8 L=0.15 W=2 nf=1 ad=0.58 as=0.58 pd=4.58 ps=4.58 nrd=0.145 nrs=0.145 sa=0 sb=0 sd=0
+ mult=1 m=1
XM7 nvout vout vss vss sky130_fd_pr__nfet_01v8 L=0.15 W=1 nf=1 ad=0.29 as=0.29 pd=2.58 ps=2.58 nrd=0.29 nrs=0.29 sa=0 sb=0 sd=0
+ mult=1 m=1
.ends

* expanding   symbol:  /foss/designs/SNN-MWIP/VCCS/otavccs4.sym # of pins=6
** sym_path: /foss/designs/SNN-MWIP/VCCS/otavccs4.sym
** sch_path: /foss/designs/SNN-MWIP/VCCS/otavccs4.sch
.subckt otavccs4 avdd ipos1 ineg1 vin1 vin2 avss
*.iopin avdd
*.iopin avss
*.ipin vin1
*.ipin vin2
*.opin ineg1
*.opin ipos1
XM2 x vin1 net2 avss sky130_fd_pr__nfet_01v8 L=0.5 W=0.5 nf=1 ad=0.145 as=0.145 pd=1.58 ps=1.58 nrd=0.58 nrs=0.58 sa=0 sb=0 sd=0
+ mult=1 m=1
XM1 y vin2 net1 avss sky130_fd_pr__nfet_01v8 L=0.5 W=0.5 nf=1 ad=0.145 as=0.145 pd=1.58 ps=1.58 nrd=0.58 nrs=0.58 sa=0 sb=0 sd=0
+ mult=1 m=1
XM11 x x avdd avdd sky130_fd_pr__pfet_01v8 L=0.15 W=0.8 nf=1 ad=0.232 as=0.232 pd=2.18 ps=2.18 nrd=0.3625 nrs=0.3625 sa=0 sb=0
+ sd=0 mult=1 m=1
XM3 y y avdd avdd sky130_fd_pr__pfet_01v8 L=0.15 W=0.8 nf=1 ad=0.232 as=0.232 pd=2.18 ps=2.18 nrd=0.3625 nrs=0.3625 sa=0 sb=0 sd=0
+ mult=1 m=1
XM5 net3 y avdd avdd sky130_fd_pr__pfet_01v8 L=0.5 W=0.5 nf=1 ad=0.145 as=0.145 pd=1.58 ps=1.58 nrd=0.58 nrs=0.58 sa=0 sb=0 sd=0
+ mult=1 m=1
XM6 ipos1 y net3 avdd sky130_fd_pr__pfet_01v8 L=0.5 W=0.5 nf=1 ad=0.145 as=0.145 pd=1.58 ps=1.58 nrd=0.58 nrs=0.58 sa=0 sb=0 sd=0
+ mult=1 m=1
XM7 net4 x avdd avdd sky130_fd_pr__pfet_01v8 L=0.5 W=0.5 nf=1 ad=0.145 as=0.145 pd=1.58 ps=1.58 nrd=0.58 nrs=0.58 sa=0 sb=0 sd=0
+ mult=1 m=1
XM8 ineg1 x net4 avdd sky130_fd_pr__pfet_01v8 L=0.5 W=0.5 nf=1 ad=0.145 as=0.145 pd=1.58 ps=1.58 nrd=0.58 nrs=0.58 sa=0 sb=0 sd=0
+ mult=1 m=1
R3 p avss 10k m=1
R6 p net2 40k m=1
R1 p net1 40k m=1
.ends

* expanding   symbol:  Synapse/stdp_min.sym # of pins=7
** sym_path: /foss/designs/SNN-MWIP/Synapse/stdp_min.sym
** sch_path: /foss/designs/SNN-MWIP/Synapse/stdp_min.sch
.subckt stdp_min vdd vss vout_pre vout_post I_post n_vout_pre n_vout_post
*.iopin vdd
*.iopin vss
*.iopin vout_post
*.iopin vout_pre
*.iopin I_post
*.iopin n_vout_post
*.iopin n_vout_pre
XM3 be vout_post vss vss sky130_fd_pr__nfet_01v8 L=0.15 W=0.5 nf=1 ad='int((nf+1)/2) * W/nf * 0.29' as='int((nf+2)/2) * W/nf * 0.29'
+ pd='2*int((nf+1)/2) * (W/nf + 0.29)' ps='2*int((nf+2)/2) * (W/nf + 0.29)' nrd='0.29 / W' nrs='0.29 / W' sa=0 sb=0 sd=0 mult=1 m=1
XM4 net1 vout_pre vss vss sky130_fd_pr__nfet_01v8 L=0.15 W=0.5 nf=1 ad='int((nf+1)/2) * W/nf * 0.29' as='int((nf+2)/2) * W/nf * 0.29'
+ pd='2*int((nf+1)/2) * (W/nf + 0.29)' ps='2*int((nf+2)/2) * (W/nf + 0.29)' nrd='0.29 / W' nrs='0.29 / W' sa=0 sb=0 sd=0 mult=1 m=1
XM14 net3 net2 vdd vdd sky130_fd_pr__pfet_01v8 L=0.15 W=0.5 nf=1 ad='int((nf+1)/2) * W/nf * 0.29' as='int((nf+2)/2) * W/nf * 0.29'
+ pd='2*int((nf+1)/2) * (W/nf + 0.29)' ps='2*int((nf+2)/2) * (W/nf + 0.29)' nrd='0.29 / W' nrs='0.29 / W' sa=0 sb=0 sd=0 mult=1 m=1
XM15 net2 net2 vdd vdd sky130_fd_pr__pfet_01v8 L=0.15 W=1 nf=1 ad='int((nf+1)/2) * W/nf * 0.29' as='int((nf+2)/2) * W/nf * 0.29' pd='2*int((nf+1)/2) * (W/nf + 0.29)'
+ ps='2*int((nf+2)/2) * (W/nf + 0.29)' nrd='0.29 / W' nrs='0.29 / W' sa=0 sb=0 sd=0 mult=1 m=1
**** begin user architecture code

.save v(te) v(be) i(vmr)

**** end user architecture code
Vmr te net1 0
.save i(vmr)
XM1 net1 n_vout_post net2 vdd sky130_fd_pr__pfet_01v8 L=0.15 W=1 nf=1 ad='int((nf+1)/2) * W/nf * 0.29' as='int((nf+2)/2) * W/nf * 0.29'
+ pd='2*int((nf+1)/2) * (W/nf + 0.29)' ps='2*int((nf+2)/2) * (W/nf + 0.29)' nrd='0.29 / W' nrs='0.29 / W' sa=0 sb=0 sd=0 mult=1 m=1
XM2 be n_vout_pre net2 vdd sky130_fd_pr__pfet_01v8 L=0.15 W=1 nf=1 ad='int((nf+1)/2) * W/nf * 0.29' as='int((nf+2)/2) * W/nf * 0.29'
+ pd='2*int((nf+1)/2) * (W/nf + 0.29)' ps='2*int((nf+2)/2) * (W/nf + 0.29)' nrd='0.29 / W' nrs='0.29 / W' sa=0 sb=0 sd=0 mult=1 m=1
XM6 I_post net2 net3 vdd sky130_fd_pr__pfet_01v8 L=0.15 W=0.5 nf=1 ad='int((nf+1)/2) * W/nf * 0.29' as='int((nf+2)/2) * W/nf * 0.29'
+ pd='2*int((nf+1)/2) * (W/nf + 0.29)' ps='2*int((nf+2)/2) * (W/nf + 0.29)' nrd='0.29 / W' nrs='0.29 / W' sa=0 sb=0 sd=0 mult=1 m=1
XR2 be te rram_v1
.ends

* expanding   symbol:  /foss/designs/SNN-MWIP/layer/integrator.sym # of pins=4
** sym_path: /foss/designs/SNN-MWIP/layer/integrator.sym
** sch_path: /foss/designs/SNN-MWIP/layer/integrator.sch
.subckt integrator vdd Vout Ispks gnd
*.iopin Ispks
*.iopin Vout
*.iopin vdd
*.iopin gnd
XMIn Ispks vx vsyn vdd sky130_fd_pr__pfet_01v8 L=0.15 W=5 nf=1 ad='int((nf+1)/2) * W/nf * 0.29' as='int((nf+2)/2) * W/nf * 0.29' pd='2*int((nf+1)/2) * (W/nf + 0.29)'
+ ps='2*int((nf+2)/2) * (W/nf + 0.29)' nrd='0.29 / W' nrs='0.29 / W' sa=0 sb=0 sd=0 mult=1 m=1
XM3 vsyn vdd vdd vdd sky130_fd_pr__pfet_01v8 L=0.15 W=50 nf=1 ad='int((nf+1)/2) * W/nf * 0.29' as='int((nf+2)/2) * W/nf * 0.29' pd='2*int((nf+1)/2) * (W/nf + 0.29)'
+ ps='2*int((nf+2)/2) * (W/nf + 0.29)' nrd='0.29 / W' nrs='0.29 / W' sa=0 sb=0 sd=0 mult=3 m=3
XM4 Vout vsyn vdd vdd sky130_fd_pr__pfet_01v8 L=0.15 W=25 nf=1 ad='int((nf+1)/2) * W/nf * 0.29' as='int((nf+2)/2) * W/nf * 0.29' pd='2*int((nf+1)/2) * (W/nf + 0.29)'
+ ps='2*int((nf+2)/2) * (W/nf + 0.29)' nrd='0.29 / W' nrs='0.29 / W' sa=0 sb=0 sd=0 mult=2 m=2
XCsyn vdd vsyn sky130_fd_pr__cap_mim_m3_1 W=22.2 L=22.2 MF=1 m=1
XR2 vx vdd sky130_fd_pr__res_generic_po W=1 L=1 m=1
XR1 gnd vx sky130_fd_pr__res_generic_po W=1 L=1 m=1
XM6 Vout vx gnd gnd sky130_fd_pr__nfet_01v8 L=0.15 W=0.5 nf=1 ad='int((nf+1)/2) * W/nf * 0.29' as='int((nf+2)/2) * W/nf * 0.29' pd='2*int((nf+1)/2) * (W/nf + 0.29)'
+ ps='2*int((nf+2)/2) * (W/nf + 0.29)' nrd='0.29 / W' nrs='0.29 / W' sa=0 sb=0 sd=0 mult=1 m=1
.ends

.GLOBAL VDD
.GLOBAL GND
.GLOBAL avss
.GLOBAL avdd
.end
